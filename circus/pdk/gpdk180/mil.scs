subckt op B INP INN O VDD VSS
    MNCM11 (B  B   VSS VSS) nmos1 m=Mcm11 w=Wcm1 l=Lcm1 \
        as=(((Wcm1) / (1)) < 599.5n) ? (((((200n > (((400n) - 200n) + 400n)) ? 200n : (((400n) - 200n) + 400n)) * 600n) + (((Wcm1) / (1)) * 200n)) + (floor(((1) - 1) / 2.0) * (((((400n) - 200n) + 400n) * 600n) + (((Wcm1) / (1)) * 400n))) + ((((1) / 2) - floor((1) / 2) == 0) ? ((((200n > (((400n) - 200n) + 400n)) ? 200n : (((400n) - 200n) + 400n)) * 600n) + (((Wcm1) / (1)) * 200n)) : 0)) / 1 : ((((400n > (((400n) - 200n) + 400n)) ? 400n : (((400n) - 200n) + 400n)) * ((Wcm1) / (1))) + (floor(((1) - 1) / 2.0) * ((((400n) - 200n) + 400n) * ((Wcm1) / (1)))) + ((((1) / 2) - floor((1) / 2) == 0) ? (((400n > (((400n) - 200n) + 400n)) ? 400n : (((400n) - 200n) + 400n)) * ((Wcm1) / (1))) : 0)) / 1 \
        ad=(((Wcm1) / (1)) < 599.5n) ? ((floor((1) / 2.0) * (((((400n) - 200n) + 400n) * 600n) + (((Wcm1) / (1)) * 400n))) + ((((1) / 2) - floor((1) / 2) != 0) ? ((((200n > (((400n) - 200n) + 400n)) ? 200n : (((400n) - 200n) + 400n)) * 600n) + (((Wcm1) / (1)) * 200n)) : 0)) / 1 : ((floor((1) / 2.0) * ((((400n) - 200n) + 400n) * ((Wcm1) / (1)))) + ((((1) / 2) - floor((1) / 2) != 0) ? (((400n > (((400n) - 200n) + 400n)) ? 400n : (((400n) - 200n) + 400n)) * ((Wcm1) / (1))) : 0)) / 1 \
        ps=(((Wcm1) / (1)) < 599.5n) ? (((2 * ((200n > (((400n) - 200n) + 400n)) ? 200n : (((400n) - 200n) + 400n))) + 1.6u) + (floor(((1) - 1) / 2.0) * ((2 * (((400n) - 200n) + 400n)) + 2u)) + ((((1) / 2) - floor((1) / 2) == 0) ? ((2 * ((200n > (((400n) - 200n) + 400n)) ? 200n : (((400n) - 200n) + 400n))) + 1.6u) : 0)) / 1 : (((2 * ((400n > (((400n) - 200n) + 400n)) ? 400n : (((400n) - 200n) + 400n))) + (2 * ((Wcm1) / (1)))) + (floor(((1) - 1) / 2.0) * ((2 * (((400n) - 200n) + 400n)) + (2 * ((Wcm1) / (1))))) + ((((1) / 2) - floor((1) / 2) == 0) ? ((2 * ((400n > (((400n) - 200n) + 400n)) ? 400n : (((400n) - 200n) + 400n))) + (2 * ((Wcm1) / (1)))) : 0)) / 1 \
        pd=(((Wcm1) / (1)) < 599.5n) ? ((floor((1) / 2.0) * ((2 * (((400n) - 200n) + 400n)) + 2u)) + ((((1) / 2) - floor((1) / 2) != 0) ? ((2 * ((200n > (((400n) - 200n) + 400n)) ? 200n : (((400n) - 200n) + 400n))) + 1.6u) : 0)) / 1 : ((floor((1) / 2.0) * ((2 * (((400n) - 200n) + 400n)) + (2 * ((Wcm1) / (1))))) + ((((1) / 2) - floor((1) / 2) != 0) ? ((2 * ((400n > (((400n) - 200n) + 400n)) ? 400n : (((400n) - 200n) + 400n))) + (2 * ((Wcm1) / (1)))) : 0)) / 1
    MNCM12 (CM B   VSS VSS) nmos1 m=Mcm12 w=Wcm1 l=Lcm1 \
        as=(((Wcm1) / (1)) < 599.5n) ? (((((200n > (((400n) - 200n) + 400n)) ? 200n : (((400n) - 200n) + 400n)) * 600n) + (((Wcm1) / (1)) * 200n)) + (floor(((1) - 1) / 2.0) * (((((400n) - 200n) + 400n) * 600n) + (((Wcm1) / (1)) * 400n))) + ((((1) / 2) - floor((1) / 2) == 0) ? ((((200n > (((400n) - 200n) + 400n)) ? 200n : (((400n) - 200n) + 400n)) * 600n) + (((Wcm1) / (1)) * 200n)) : 0)) / 1 : ((((400n > (((400n) - 200n) + 400n)) ? 400n : (((400n) - 200n) + 400n)) * ((Wcm1) / (1))) + (floor(((1) - 1) / 2.0) * ((((400n) - 200n) + 400n) * ((Wcm1) / (1)))) + ((((1) / 2) - floor((1) / 2) == 0) ? (((400n > (((400n) - 200n) + 400n)) ? 400n : (((400n) - 200n) + 400n)) * ((Wcm1) / (1))) : 0)) / 1 \
        ad=(((Wcm1) / (1)) < 599.5n) ? ((floor((1) / 2.0) * (((((400n) - 200n) + 400n) * 600n) + (((Wcm1) / (1)) * 400n))) + ((((1) / 2) - floor((1) / 2) != 0) ? ((((200n > (((400n) - 200n) + 400n)) ? 200n : (((400n) - 200n) + 400n)) * 600n) + (((Wcm1) / (1)) * 200n)) : 0)) / 1 : ((floor((1) / 2.0) * ((((400n) - 200n) + 400n) * ((Wcm1) / (1)))) + ((((1) / 2) - floor((1) / 2) != 0) ? (((400n > (((400n) - 200n) + 400n)) ? 400n : (((400n) - 200n) + 400n)) * ((Wcm1) / (1))) : 0)) / 1 \
        ps=(((Wcm1) / (1)) < 599.5n) ? (((2 * ((200n > (((400n) - 200n) + 400n)) ? 200n : (((400n) - 200n) + 400n))) + 1.6u) + (floor(((1) - 1) / 2.0) * ((2 * (((400n) - 200n) + 400n)) + 2u)) + ((((1) / 2) - floor((1) / 2) == 0) ? ((2 * ((200n > (((400n) - 200n) + 400n)) ? 200n : (((400n) - 200n) + 400n))) + 1.6u) : 0)) / 1 : (((2 * ((400n > (((400n) - 200n) + 400n)) ? 400n : (((400n) - 200n) + 400n))) + (2 * ((Wcm1) / (1)))) + (floor(((1) - 1) / 2.0) * ((2 * (((400n) - 200n) + 400n)) + (2 * ((Wcm1) / (1))))) + ((((1) / 2) - floor((1) / 2) == 0) ? ((2 * ((400n > (((400n) - 200n) + 400n)) ? 400n : (((400n) - 200n) + 400n))) + (2 * ((Wcm1) / (1)))) : 0)) / 1 \
        pd=(((Wcm1) / (1)) < 599.5n) ? ((floor((1) / 2.0) * ((2 * (((400n) - 200n) + 400n)) + 2u)) + ((((1) / 2) - floor((1) / 2) != 0) ? ((2 * ((200n > (((400n) - 200n) + 400n)) ? 200n : (((400n) - 200n) + 400n))) + 1.6u) : 0)) / 1 : ((floor((1) / 2.0) * ((2 * (((400n) - 200n) + 400n)) + (2 * ((Wcm1) / (1))))) + ((((1) / 2) - floor((1) / 2) != 0) ? ((2 * ((400n > (((400n) - 200n) + 400n)) ? 400n : (((400n) - 200n) + 400n))) + (2 * ((Wcm1) / (1)))) : 0)) / 1
    MNCM13 (O  B   VSS VSS) nmos1 m=Mcm13 w=Wcm1 l=Lcm1 \
        as=(((Wcm1) / (1)) < 599.5n) ? (((((200n > (((400n) - 200n) + 400n)) ? 200n : (((400n) - 200n) + 400n)) * 600n) + (((Wcm1) / (1)) * 200n)) + (floor(((1) - 1) / 2.0) * (((((400n) - 200n) + 400n) * 600n) + (((Wcm1) / (1)) * 400n))) + ((((1) / 2) - floor((1) / 2) == 0) ? ((((200n > (((400n) - 200n) + 400n)) ? 200n : (((400n) - 200n) + 400n)) * 600n) + (((Wcm1) / (1)) * 200n)) : 0)) / 1 : ((((400n > (((400n) - 200n) + 400n)) ? 400n : (((400n) - 200n) + 400n)) * ((Wcm1) / (1))) + (floor(((1) - 1) / 2.0) * ((((400n) - 200n) + 400n) * ((Wcm1) / (1)))) + ((((1) / 2) - floor((1) / 2) == 0) ? (((400n > (((400n) - 200n) + 400n)) ? 400n : (((400n) - 200n) + 400n)) * ((Wcm1) / (1))) : 0)) / 1 \
        ad=(((Wcm1) / (1)) < 599.5n) ? ((floor((1) / 2.0) * (((((400n) - 200n) + 400n) * 600n) + (((Wcm1) / (1)) * 400n))) + ((((1) / 2) - floor((1) / 2) != 0) ? ((((200n > (((400n) - 200n) + 400n)) ? 200n : (((400n) - 200n) + 400n)) * 600n) + (((Wcm1) / (1)) * 200n)) : 0)) / 1 : ((floor((1) / 2.0) * ((((400n) - 200n) + 400n) * ((Wcm1) / (1)))) + ((((1) / 2) - floor((1) / 2) != 0) ? (((400n > (((400n) - 200n) + 400n)) ? 400n : (((400n) - 200n) + 400n)) * ((Wcm1) / (1))) : 0)) / 1 \
        ps=(((Wcm1) / (1)) < 599.5n) ? (((2 * ((200n > (((400n) - 200n) + 400n)) ? 200n : (((400n) - 200n) + 400n))) + 1.6u) + (floor(((1) - 1) / 2.0) * ((2 * (((400n) - 200n) + 400n)) + 2u)) + ((((1) / 2) - floor((1) / 2) == 0) ? ((2 * ((200n > (((400n) - 200n) + 400n)) ? 200n : (((400n) - 200n) + 400n))) + 1.6u) : 0)) / 1 : (((2 * ((400n > (((400n) - 200n) + 400n)) ? 400n : (((400n) - 200n) + 400n))) + (2 * ((Wcm1) / (1)))) + (floor(((1) - 1) / 2.0) * ((2 * (((400n) - 200n) + 400n)) + (2 * ((Wcm1) / (1))))) + ((((1) / 2) - floor((1) / 2) == 0) ? ((2 * ((400n > (((400n) - 200n) + 400n)) ? 400n : (((400n) - 200n) + 400n))) + (2 * ((Wcm1) / (1)))) : 0)) / 1 \
        pd=(((Wcm1) / (1)) < 599.5n) ? ((floor((1) / 2.0) * ((2 * (((400n) - 200n) + 400n)) + 2u)) + ((((1) / 2) - floor((1) / 2) != 0) ? ((2 * ((200n > (((400n) - 200n) + 400n)) ? 200n : (((400n) - 200n) + 400n))) + 1.6u) : 0)) / 1 : ((floor((1) / 2.0) * ((2 * (((400n) - 200n) + 400n)) + (2 * ((Wcm1) / (1))))) + ((((1) / 2) - floor((1) / 2) != 0) ? ((2 * ((400n > (((400n) - 200n) + 400n)) ? 400n : (((400n) - 200n) + 400n))) + (2 * ((Wcm1) / (1)))) : 0)) / 1

    MNDP11 (Y  INP CM  VSS) nmos1 m=Mdp11 w=Wdp1 l=Ldp1 \
        as=(((Wdp1) / (1)) < 599.5n) ? (((((200n > (((400n) - 200n) + 400n)) ? 200n : (((400n) - 200n) + 400n)) * 600n) + (((Wdp1) / (1)) * 200n)) + (floor(((1) - 1) / 2.0) * (((((400n) - 200n) + 400n) * 600n) + (((Wdp1) / (1)) * 400n))) + ((((1) / 2) - floor((1) / 2) == 0) ? ((((200n > (((400n) - 200n) + 400n)) ? 200n : (((400n) - 200n) + 400n)) * 600n) + (((Wdp1) / (1)) * 200n)) : 0)) / 1 : ((((400n > (((400n) - 200n) + 400n)) ? 400n : (((400n) - 200n) + 400n)) * ((Wdp1) / (1))) + (floor(((1) - 1) / 2.0) * ((((400n) - 200n) + 400n) * ((Wdp1) / (1)))) + ((((1) / 2) - floor((1) / 2) == 0) ? (((400n > (((400n) - 200n) + 400n)) ? 400n : (((400n) - 200n) + 400n)) * ((Wdp1) / (1))) : 0)) / 1 \
        ad=(((Wdp1) / (1)) < 599.5n) ? ((floor((1) / 2.0) * (((((400n) - 200n) + 400n) * 600n) + (((Wdp1) / (1)) * 400n))) + ((((1) / 2) - floor((1) / 2) != 0) ? ((((200n > (((400n) - 200n) + 400n)) ? 200n : (((400n) - 200n) + 400n)) * 600n) + (((Wdp1) / (1)) * 200n)) : 0)) / 1 : ((floor((1) / 2.0) * ((((400n) - 200n) + 400n) * ((Wdp1) / (1)))) + ((((1) / 2) - floor((1) / 2) != 0) ? (((400n > (((400n) - 200n) + 400n)) ? 400n : (((400n) - 200n) + 400n)) * ((Wdp1) / (1))) : 0)) / 1 \
        ps=(((Wdp1) / (1)) < 599.5n) ? (((2 * ((200n > (((400n) - 200n) + 400n)) ? 200n : (((400n) - 200n) + 400n))) + 1.6u) + (floor(((1) - 1) / 2.0) * ((2 * (((400n) - 200n) + 400n)) + 2u)) + ((((1) / 2) - floor((1) / 2) == 0) ? ((2 * ((200n > (((400n) - 200n) + 400n)) ? 200n : (((400n) - 200n) + 400n))) + 1.6u) : 0)) / 1 : (((2 * ((400n > (((400n) - 200n) + 400n)) ? 400n : (((400n) - 200n) + 400n))) + (2 * ((Wdp1) / (1)))) + (floor(((1) - 1) / 2.0) * ((2 * (((400n) - 200n) + 400n)) + (2 * ((Wdp1) / (1))))) + ((((1) / 2) - floor((1) / 2) == 0) ? ((2 * ((400n > (((400n) - 200n) + 400n)) ? 400n : (((400n) - 200n) + 400n))) + (2 * ((Wdp1) / (1)))) : 0)) / 1 \
        pd=(((Wdp1) / (1)) < 599.5n) ? ((floor((1) / 2.0) * ((2 * (((400n) - 200n) + 400n)) + 2u)) + ((((1) / 2) - floor((1) / 2) != 0) ? ((2 * ((200n > (((400n) - 200n) + 400n)) ? 200n : (((400n) - 200n) + 400n))) + 1.6u) : 0)) / 1 : ((floor((1) / 2.0) * ((2 * (((400n) - 200n) + 400n)) + (2 * ((Wdp1) / (1))))) + ((((1) / 2) - floor((1) / 2) != 0) ? ((2 * ((400n > (((400n) - 200n) + 400n)) ? 400n : (((400n) - 200n) + 400n))) + (2 * ((Wdp1) / (1)))) : 0)) / 1
    MNDP12 (X  INN CM  VSS) nmos1 m=Mdp12 w=Wdp1 l=Ldp1 \
        as=(((Wdp1) / (1)) < 599.5n) ? (((((200n > (((400n) - 200n) + 400n)) ? 200n : (((400n) - 200n) + 400n)) * 600n) + (((Wdp1) / (1)) * 200n)) + (floor(((1) - 1) / 2.0) * (((((400n) - 200n) + 400n) * 600n) + (((Wdp1) / (1)) * 400n))) + ((((1) / 2) - floor((1) / 2) == 0) ? ((((200n > (((400n) - 200n) + 400n)) ? 200n : (((400n) - 200n) + 400n)) * 600n) + (((Wdp1) / (1)) * 200n)) : 0)) / 1 : ((((400n > (((400n) - 200n) + 400n)) ? 400n : (((400n) - 200n) + 400n)) * ((Wdp1) / (1))) + (floor(((1) - 1) / 2.0) * ((((400n) - 200n) + 400n) * ((Wdp1) / (1)))) + ((((1) / 2) - floor((1) / 2) == 0) ? (((400n > (((400n) - 200n) + 400n)) ? 400n : (((400n) - 200n) + 400n)) * ((Wdp1) / (1))) : 0)) / 1 \
        ad=(((Wdp1) / (1)) < 599.5n) ? ((floor((1) / 2.0) * (((((400n) - 200n) + 400n) * 600n) + (((Wdp1) / (1)) * 400n))) + ((((1) / 2) - floor((1) / 2) != 0) ? ((((200n > (((400n) - 200n) + 400n)) ? 200n : (((400n) - 200n) + 400n)) * 600n) + (((Wdp1) / (1)) * 200n)) : 0)) / 1 : ((floor((1) / 2.0) * ((((400n) - 200n) + 400n) * ((Wdp1) / (1)))) + ((((1) / 2) - floor((1) / 2) != 0) ? (((400n > (((400n) - 200n) + 400n)) ? 400n : (((400n) - 200n) + 400n)) * ((Wdp1) / (1))) : 0)) / 1 \
        ps=(((Wdp1) / (1)) < 599.5n) ? (((2 * ((200n > (((400n) - 200n) + 400n)) ? 200n : (((400n) - 200n) + 400n))) + 1.6u) + (floor(((1) - 1) / 2.0) * ((2 * (((400n) - 200n) + 400n)) + 2u)) + ((((1) / 2) - floor((1) / 2) == 0) ? ((2 * ((200n > (((400n) - 200n) + 400n)) ? 200n : (((400n) - 200n) + 400n))) + 1.6u) : 0)) / 1 : (((2 * ((400n > (((400n) - 200n) + 400n)) ? 400n : (((400n) - 200n) + 400n))) + (2 * ((Wdp1) / (1)))) + (floor(((1) - 1) / 2.0) * ((2 * (((400n) - 200n) + 400n)) + (2 * ((Wdp1) / (1))))) + ((((1) / 2) - floor((1) / 2) == 0) ? ((2 * ((400n > (((400n) - 200n) + 400n)) ? 400n : (((400n) - 200n) + 400n))) + (2 * ((Wdp1) / (1)))) : 0)) / 1 \
        pd=(((Wdp1) / (1)) < 599.5n) ? ((floor((1) / 2.0) * ((2 * (((400n) - 200n) + 400n)) + 2u)) + ((((1) / 2) - floor((1) / 2) != 0) ? ((2 * ((200n > (((400n) - 200n) + 400n)) ? 200n : (((400n) - 200n) + 400n))) + 1.6u) : 0)) / 1 : ((floor((1) / 2.0) * ((2 * (((400n) - 200n) + 400n)) + (2 * ((Wdp1) / (1))))) + ((((1) / 2) - floor((1) / 2) != 0) ? ((2 * ((400n > (((400n) - 200n) + 400n)) ? 400n : (((400n) - 200n) + 400n))) + (2 * ((Wdp1) / (1)))) : 0)) / 1

    MPCM21 (X  X   VDD VDD) pmos1 m=Mcm21 w=Wcm2 l=Lcm2 \
        as=(((Wcm2) / (1)) < 599.5n) ? (((((200n > (((400n) - 200n) + 400n)) ? 200n : (((400n) - 200n) + 400n)) * 600n) + (((Wcm2) / (1)) * 200n)) + (floor(((1) - 1) / 2.0) * (((((400n) - 200n) + 400n) * 600n) + (((Wcm2) / (1)) * 400n))) + ((((1) / 2) - floor((1) / 2) == 0) ? ((((200n > (((400n) - 200n) + 400n)) ? 200n : (((400n) - 200n) + 400n)) * 600n) + (((Wcm2) / (1)) * 200n)) : 0)) / 1 : ((((400n > (((400n) - 200n) + 400n)) ? 400n : (((400n) - 200n) + 400n)) * ((Wcm2) / (1))) + (floor(((1) - 1) / 2.0) * ((((400n) - 200n) + 400n) * ((Wcm2) / (1)))) + ((((1) / 2) - floor((1) / 2) == 0) ? (((400n > (((400n) - 200n) + 400n)) ? 400n : (((400n) - 200n) + 400n)) * ((Wcm2) / (1))) : 0)) / 1 \
        ad=(((Wcm2) / (1)) < 599.5n) ? ((floor((1) / 2.0) * (((((400n) - 200n) + 400n) * 600n) + (((Wcm2) / (1)) * 400n))) + ((((1) / 2) - floor((1) / 2) != 0) ? ((((200n > (((400n) - 200n) + 400n)) ? 200n : (((400n) - 200n) + 400n)) * 600n) + (((Wcm2) / (1)) * 200n)) : 0)) / 1 : ((floor((1) / 2.0) * ((((400n) - 200n) + 400n) * ((Wcm2) / (1)))) + ((((1) / 2) - floor((1) / 2) != 0) ? (((400n > (((400n) - 200n) + 400n)) ? 400n : (((400n) - 200n) + 400n)) * ((Wcm2) / (1))) : 0)) / 1 \
        ps=(((Wcm2) / (1)) < 599.5n) ? (((2 * ((200n > (((400n) - 200n) + 400n)) ? 200n : (((400n) - 200n) + 400n))) + 1.6u) + (floor(((1) - 1) / 2.0) * ((2 * (((400n) - 200n) + 400n)) + 2u)) + ((((1) / 2) - floor((1) / 2) == 0) ? ((2 * ((200n > (((400n) - 200n) + 400n)) ? 200n : (((400n) - 200n) + 400n))) + 1.6u) : 0)) / 1 : (((2 * ((400n > (((400n) - 200n) + 400n)) ? 400n : (((400n) - 200n) + 400n))) + (2 * ((Wcm2) / (1)))) + (floor(((1) - 1) / 2.0) * ((2 * (((400n) - 200n) + 400n)) + (2 * ((Wcm2) / (1))))) + ((((1) / 2) - floor((1) / 2) == 0) ? ((2 * ((400n > (((400n) - 200n) + 400n)) ? 400n : (((400n) - 200n) + 400n))) + (2 * ((Wcm2) / (1)))) : 0)) / 1 \
        pd=(((Wcm2) / (1)) < 599.5n) ? ((floor((1) / 2.0) * ((2 * (((400n) - 200n) + 400n)) + 2u)) + ((((1) / 2) - floor((1) / 2) != 0) ? ((2 * ((200n > (((400n) - 200n) + 400n)) ? 200n : (((400n) - 200n) + 400n))) + 1.6u) : 0)) / 1 : ((floor((1) / 2.0) * ((2 * (((400n) - 200n) + 400n)) + (2 * ((Wcm2) / (1))))) + ((((1) / 2) - floor((1) / 2) != 0) ? ((2 * ((400n > (((400n) - 200n) + 400n)) ? 400n : (((400n) - 200n) + 400n))) + (2 * ((Wcm2) / (1)))) : 0)) / 1
    MPCM22 (Y  X   VDD VDD) pmos1 m=Mcm22 w=Wcm2 l=Lcm2 \
        as=(((Wcm2) / (1)) < 599.5n) ? (((((200n > (((400n) - 200n) + 400n)) ? 200n : (((400n) - 200n) + 400n)) * 600n) + (((Wcm2) / (1)) * 200n)) + (floor(((1) - 1) / 2.0) * (((((400n) - 200n) + 400n) * 600n) + (((Wcm2) / (1)) * 400n))) + ((((1) / 2) - floor((1) / 2) == 0) ? ((((200n > (((400n) - 200n) + 400n)) ? 200n : (((400n) - 200n) + 400n)) * 600n) + (((Wcm2) / (1)) * 200n)) : 0)) / 1 : ((((400n > (((400n) - 200n) + 400n)) ? 400n : (((400n) - 200n) + 400n)) * ((Wcm2) / (1))) + (floor(((1) - 1) / 2.0) * ((((400n) - 200n) + 400n) * ((Wcm2) / (1)))) + ((((1) / 2) - floor((1) / 2) == 0) ? (((400n > (((400n) - 200n) + 400n)) ? 400n : (((400n) - 200n) + 400n)) * ((Wcm2) / (1))) : 0)) / 1 \
        ad=(((Wcm2) / (1)) < 599.5n) ? ((floor((1) / 2.0) * (((((400n) - 200n) + 400n) * 600n) + (((Wcm2) / (1)) * 400n))) + ((((1) / 2) - floor((1) / 2) != 0) ? ((((200n > (((400n) - 200n) + 400n)) ? 200n : (((400n) - 200n) + 400n)) * 600n) + (((Wcm2) / (1)) * 200n)) : 0)) / 1 : ((floor((1) / 2.0) * ((((400n) - 200n) + 400n) * ((Wcm2) / (1)))) + ((((1) / 2) - floor((1) / 2) != 0) ? (((400n > (((400n) - 200n) + 400n)) ? 400n : (((400n) - 200n) + 400n)) * ((Wcm2) / (1))) : 0)) / 1 \
        ps=(((Wcm2) / (1)) < 599.5n) ? (((2 * ((200n > (((400n) - 200n) + 400n)) ? 200n : (((400n) - 200n) + 400n))) + 1.6u) + (floor(((1) - 1) / 2.0) * ((2 * (((400n) - 200n) + 400n)) + 2u)) + ((((1) / 2) - floor((1) / 2) == 0) ? ((2 * ((200n > (((400n) - 200n) + 400n)) ? 200n : (((400n) - 200n) + 400n))) + 1.6u) : 0)) / 1 : (((2 * ((400n > (((400n) - 200n) + 400n)) ? 400n : (((400n) - 200n) + 400n))) + (2 * ((Wcm2) / (1)))) + (floor(((1) - 1) / 2.0) * ((2 * (((400n) - 200n) + 400n)) + (2 * ((Wcm2) / (1))))) + ((((1) / 2) - floor((1) / 2) == 0) ? ((2 * ((400n > (((400n) - 200n) + 400n)) ? 400n : (((400n) - 200n) + 400n))) + (2 * ((Wcm2) / (1)))) : 0)) / 1 \
        pd=(((Wcm2) / (1)) < 599.5n) ? ((floor((1) / 2.0) * ((2 * (((400n) - 200n) + 400n)) + 2u)) + ((((1) / 2) - floor((1) / 2) != 0) ? ((2 * ((200n > (((400n) - 200n) + 400n)) ? 200n : (((400n) - 200n) + 400n))) + 1.6u) : 0)) / 1 : ((floor((1) / 2.0) * ((2 * (((400n) - 200n) + 400n)) + (2 * ((Wcm2) / (1))))) + ((((1) / 2) - floor((1) / 2) != 0) ? ((2 * ((400n > (((400n) - 200n) + 400n)) ? 400n : (((400n) - 200n) + 400n))) + (2 * ((Wcm2) / (1)))) : 0)) / 1

    MPCS11 (O  Y   VDD VDD) pmos1 m=Mcs11 w=Wcs1 l=Lcs1 \
        as=(((Wcs1) / (1)) < 599.5n) ? (((((200n > (((400n) - 200n) + 400n)) ? 200n : (((400n) - 200n) + 400n)) * 600n) + (((Wcs1) / (1)) * 200n)) + (floor(((1) - 1) / 2.0) * (((((400n) - 200n) + 400n) * 600n) + (((Wcs1) / (1)) * 400n))) + ((((1) / 2) - floor((1) / 2) == 0) ? ((((200n > (((400n) - 200n) + 400n)) ? 200n : (((400n) - 200n) + 400n)) * 600n) + (((Wcs1) / (1)) * 200n)) : 0)) / 1 : ((((400n > (((400n) - 200n) + 400n)) ? 400n : (((400n) - 200n) + 400n)) * ((Wcs1) / (1))) + (floor(((1) - 1) / 2.0) * ((((400n) - 200n) + 400n) * ((Wcs1) / (1)))) + ((((1) / 2) - floor((1) / 2) == 0) ? (((400n > (((400n) - 200n) + 400n)) ? 400n : (((400n) - 200n) + 400n)) * ((Wcs1) / (1))) : 0)) / 1 \
        ad=(((Wcs1) / (1)) < 599.5n) ? ((floor((1) / 2.0) * (((((400n) - 200n) + 400n) * 600n) + (((Wcs1) / (1)) * 400n))) + ((((1) / 2) - floor((1) / 2) != 0) ? ((((200n > (((400n) - 200n) + 400n)) ? 200n : (((400n) - 200n) + 400n)) * 600n) + (((Wcs1) / (1)) * 200n)) : 0)) / 1 : ((floor((1) / 2.0) * ((((400n) - 200n) + 400n) * ((Wcs1) / (1)))) + ((((1) / 2) - floor((1) / 2) != 0) ? (((400n > (((400n) - 200n) + 400n)) ? 400n : (((400n) - 200n) + 400n)) * ((Wcs1) / (1))) : 0)) / 1 \
        ps=(((Wcs1) / (1)) < 599.5n) ? (((2 * ((200n > (((400n) - 200n) + 400n)) ? 200n : (((400n) - 200n) + 400n))) + 1.6u) + (floor(((1) - 1) / 2.0) * ((2 * (((400n) - 200n) + 400n)) + 2u)) + ((((1) / 2) - floor((1) / 2) == 0) ? ((2 * ((200n > (((400n) - 200n) + 400n)) ? 200n : (((400n) - 200n) + 400n))) + 1.6u) : 0)) / 1 : (((2 * ((400n > (((400n) - 200n) + 400n)) ? 400n : (((400n) - 200n) + 400n))) + (2 * ((Wcs1) / (1)))) + (floor(((1) - 1) / 2.0) * ((2 * (((400n) - 200n) + 400n)) + (2 * ((Wcs1) / (1))))) + ((((1) / 2) - floor((1) / 2) == 0) ? ((2 * ((400n > (((400n) - 200n) + 400n)) ? 400n : (((400n) - 200n) + 400n))) + (2 * ((Wcs1) / (1)))) : 0)) / 1 \
        pd=(((Wcs1) / (1)) < 599.5n) ? ((floor((1) / 2.0) * ((2 * (((400n) - 200n) + 400n)) + 2u)) + ((((1) / 2) - floor((1) / 2) != 0) ? ((2 * ((200n > (((400n) - 200n) + 400n)) ? 200n : (((400n) - 200n) + 400n))) + 1.6u) : 0)) / 1 : ((floor((1) / 2.0) * ((2 * (((400n) - 200n) + 400n)) + (2 * ((Wcs1) / (1))))) + ((((1) / 2) - floor((1) / 2) != 0) ? ((2 * ((400n > (((400n) - 200n) + 400n)) ? 400n : (((400n) - 200n) + 400n))) + (2 * ((Wcs1) / (1)))) : 0)) / 1

    CMCS11 (O A) mimcap area=(Wcap)*(Lcap) perim=2*(Wcap)+2*(Lcap) m=Mcap1
    RPCS11 (A Y) polyres_pcell_0 sl=(((7.5)*((Wres)-(0))*(1))/((7.5)*(1)))+(0) w=Wres
ends op
